// Verilog-A Neural Network Module
// Auto-generated by Psi-HDL Framework
// Model Type: SNN_XOR
// Input Dimension: 2
// Output Dimension: 1
// Total Layers: 2
//
// This module implements a neural network discovered by Psi-NN
// as an analog behavioral model suitable for SPICE simulation.

`include "constants.vams"
`include "disciplines.vams"

module psi_nn_SNN_XOR(in0, in1, out0, vdd, vss);
    // Input ports (voltage nodes)
    input in0;
    input in1;

    // Output ports (voltage nodes)
    output out0;

    // Power supply nodes
    input vdd, vss;

    // Declare port types as electrical
    electrical in0;
    electrical in1;
    electrical out0;
    electrical vdd, vss;

    // Neural network parameters (weights and biases)
    // These can be overridden during instantiation

    // layer_0
    parameter real L0_w[0:1][0:1] = 0.0;
    parameter real L0_b[0:1] = 0.0;

    // output
    parameter real output_w[0:0][0:1] = 0.0;
    parameter real output_b[0:0] = 0.0;

    // Internal variables for layer computations
    real input_vec[0:1];
    real output_vec[0:0];
    real layer_out[0:1];
    real temp_sum;
    integer i, j;

    analog begin
        // Read input voltages and normalize
        input_vec[0] = V(in0) / 1.0;
        input_vec[1] = V(in1) / 1.0;

        // Forward propagation through network
        // Standard feedforward network
        real layer_in[0:100];
        real layer_temp[0:100];

        // Copy inputs
        for (i = 0; i < 2; i = i + 1) begin
            layer_in[i] = input_vec[i];
        end

        // Layer 0: 2 -> 2
        for (i = 0; i < 2; i = i + 1) begin
            temp_sum = 0.0;
            for (j = 0; j < 2; j = j + 1) begin
                temp_sum = temp_sum + L0_w[i][j] * layer_in[j];
            end
            temp_sum = temp_sum + L0_b[i];
            layer_temp[i] = tanh(temp_sum);
        end

        for (i = 0; i < 2; i = i + 1) begin
            layer_in[i] = layer_temp[i];
        end

        // Layer 1: 2 -> 1
        for (i = 0; i < 1; i = i + 1) begin
            temp_sum = 0.0;
            for (j = 0; j < 2; j = j + 1) begin
                temp_sum = temp_sum + output_w[i][j] * layer_in[j];
            end
            temp_sum = temp_sum + output_b[i];
            layer_temp[i] = temp_sum;
        end

        for (i = 0; i < 1; i = i + 1) begin
            layer_in[i] = layer_temp[i];
        end

        // Copy to output
        for (i = 0; i < 1; i = i + 1) begin
            output_vec[i] = layer_in[i];
        end

        // Write output voltages
        V(out0) <+ output_vec[0] * 1.0;
    end

endmodule
