// Verilog-A SNN Module: 3×3 Pixel Classifier
// Generated by Ψ-HDL Framework
// Architecture: 9 → 4 → 2 (Compressed: 50.0%)

`include "disciplines.vams"

module snn_3x3_classifier(in0, in1, in2, in3, in4, in5, in6, in7, in8, out0, out1);
    input in0, in1, in2, in3, in4, in5, in6, in7, in8;
    output out0, out1;
    electrical in0, in1, in2, in3, in4, in5, in6, in7, in8;
    electrical out0, out1;

    // Hidden layer neurons
    real h0, h1, h2, h3;

    // Output neurons
    real o0, o1;

    analog begin
        // Layer 1: Input → Hidden (9 → 4)
        h0 = tanh(1.454970 + -0.869148*V(in0) + 0.271308*V(in1) + -1.300298*V(in2) + 1.650054*V(in3) + 1.819750*V(in4) + 1.683444*V(in5) + -1.258286*V(in6) + -1.155343*V(in7) + -1.402639*V(in8));
        h1 = tanh(-1.419643 + 0.861743*V(in0) + -1.521885*V(in1) + 1.397373*V(in2) + 0.887331*V(in3) + -1.697153*V(in4) + 0.161537*V(in5) + 0.969384*V(in6) + -1.626282*V(in7) + 0.039431*V(in8));
        h2 = tanh(-1.574533 + 1.210285*V(in0) + -0.430003*V(in1) + 1.433714*V(in2) + 1.255440*V(in3) + 1.432297*V(in4) + 1.350911*V(in5) + -1.828713*V(in6) + -1.900837*V(in7) + -1.918452*V(in8));
        h3 = tanh(-1.114998 + -0.968281*V(in0) + -1.128766*V(in1) + 0.930822*V(in2) + -1.350484*V(in3) + -1.289733*V(in4) + 1.260450*V(in5) + -1.476282*V(in6) + -1.407304*V(in7) + 1.409850*V(in8));

        // Layer 2: Hidden → Output (4 → 2)
        o0 = -0.077897 + 2.573119*h0 + 1.131160*h1 + -2.156305*h2 + 1.185273*h3;
        o1 = -0.677600 + -2.193308*h0 + -1.871081*h1 + 2.505452*h2 + -1.558201*h3;

        // Assign outputs
        V(out0) <+ o0;
        V(out1) <+ o1;
    end
endmodule
